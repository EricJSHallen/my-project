// Design: sebastian_thesis_pilot/dynapsetb1
simulator lang=spectre
global 0
parameters m2w=3u m2l=200n m3w=2.1u m3l=4u m4w=2.1u m4l=1.05u m5w=2.1u m5l=1.05u m4wtb=2.1u m4ltb=1.05u m2wtb=2.1u m2ltb=1.05u pw=100u T=1m Vin=0 vmax=1.8 Vw=0.5 Vthr=0.9 Vtau=1.6 capacitance=6p pwlFile_st2="/home/s5117909/Documents/thesis/thesis_codebase/experiments/frequency_sweep/input_data/spike_train_output/st_2/6001_hz/trial_1.pwl" pwlFile_st1="/home/s5117909/Documents/thesis/thesis_codebase/experiments/frequency_sweep/input_data/spike_train_output/st_1/4001_hz/trial_1.pwl"

include "/projects/bics/designkits/xfab/xp018/cadence/v8_0/spectre/v8_0_1/lp5mos/config.scs" section=default
include "/projects/bics/designkits/xfab/xp018/cadence/v8_0/spectre/v8_0_1/lp5mos/param.scs" section=3s
include "/projects/bics/designkits/xfab/xp018/cadence/v8_0/spectre/v8_0_1/lp5mos/bip.scs" section=tm
include "/projects/bics/designkits/xfab/xp018/cadence/v8_0/spectre/v8_0_1/lp5mos/cap.scs" section=tm
include "/projects/bics/designkits/xfab/xp018/cadence/v8_0/spectre/v8_0_1/lp5mos/dio.scs" section=tm
include "/projects/bics/designkits/xfab/xp018/cadence/v8_0/spectre/v8_0_1/lp5mos/mos.scs" section=tm
include "/projects/bics/designkits/xfab/xp018/cadence/v8_0/spectre/v8_0_1/lp5mos/res.scs" section=tm

// sebastian_thesis_pilot/dynapse1/schematic
subckt dynapse1 Iout Vdd Vin Vtau Vthr
    M2 (Vdd Vthr Vin 0) ne w=m2w/1 l=m2l m=(1)*(1)
    M3 (net1 net1 Vin 0) ne w=m3w/1 l=m3l m=(1)*(1)
    M4 (net1 Vtau Vdd 0) pe w=m4w/1 l=m4l m=(1)*(1)
    M5 (Iout net1 Vdd 0) pe w=m5w/1 l=m5l m=(1)*(1)
    C0 (Vdd net1) cmm4 area=5.833e-10 perimeter=98.33u m=1 par1=1
ends dynapse1

// sebastian_thesis_pilot/dynapsetb1/schematic
VSENSE_I56 (i56_iout 0) vsource dc=0 type=dc
I56 (i56_iout Vdd Vin Vtau Vthr) dynapse1
VSENSE_I172 (i172_iout 0) vsource dc=0 type=dc
I172 (i172_iout Vdd Vin1 Vtau Vthr) dynapse1
V4 (Vw 0) vsource dc=Vw type=dc
V3 (Vthr 0) vsource dc=Vthr type=dc
V2 (Vtau 0) vsource dc=Vtau type=dc
V1 (Vdd 0) vsource dc=1.8 type=dc
M0 (net1 vpre1 0 0) ne w=m2wtb/1 l=m2ltb m=(1)*(1)
M4 (Vin Vw net7 0) ne w=m4wtb/1 l=m4ltb m=(1)*(1)
M2 (net7 vpre 0 0) ne w=m2wtb/1 l=m2ltb m=(1)*(1)
M1 (Vin1 Vw net1 0) ne w=m4wtb/1 l=m4ltb m=(1)*(1)
V14 (vpre1 0) vsource type=pwl file=pwlFile_st2
V5 (vpre 0) vsource type=pwl file=pwlFile_st1
simulatorOptions options temp=27
tran tran stop=1s
save vpre vpre1 VSENSE_I172:p VSENSE_I172:n VSENSE_I56:p VSENSE_I56:n I172:Iout I56:Iout
saveOptions options currents=all
