; Export one plain-Spectre PSF result directory to output_signals.txt.
caseDir = getShellEnvVar("CASE_DIR")
when(caseDir == nil
  error("CASE_DIR is not set.\n")
)
psfDir = strcat(caseDir "/psf")
outFile = strcat(caseDir "/output_signals.txt")
outTmp = strcat(caseDir "/output_signals.txt.tmp")
unless(isDir(psfDir)
  error("Cannot find PSF directory: %s\n" psfDir)
)
when(isFile(outTmp)
  system(strcat("rm -f \"" outTmp "\""))
)
openResults(psfDir)
selectResult('tran)
iout_56 = i("/I56/Iout")
vpre = v("/vpre")
vpre1 = v("/vpre1")
ocnPrint(?output outTmp ?precision 10 ?numSpaces 1 iout_56 vpre vpre1)
closeResults(psfDir)
system(strcat("mv -f \"" outTmp "\" \"" outFile "\""))
printf("Exported output_signals.txt for %s\n" caseDir)
exit()
